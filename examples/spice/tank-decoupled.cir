* tank.cir behind a decoupled rail. rsup is the supply impedance and
* cdec shunts the noise away, so good power integrity works against
* noise-driven startup.
rsup vcc rail 10
cdec rail 0 100n
rs rail tank 10k
l1 tank lmid 1u
rl lmid 0 1.3
c1 tank 0 235p
