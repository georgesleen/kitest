* Passive LC tank on a supply rail. No active device, so nothing but
* supply noise can excite it: an ideal rail leaves this node dead.
* Resonates at 1 / (2 pi sqrt(L C)) = 10.38 MHz, and rs sets the
* loaded Q to about 150, which is a resonance 0.65% wide.
rs vcc tank 10k
l1 tank 0 1u
c1 tank 0 235p
